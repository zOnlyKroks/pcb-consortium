.title KiCad schematic
.include "C:/Users/finnr/Desktop/pcb-consortium/AMP/D-V1/models/DV1_models.lib"
.model SWSHORT SW(Ron=20m Roff=100Meg Vt=0.5 Vh=0.05)
VSHORT shortctl 0 PWL(0 0 6.25m 0 6.26m 1)
SSHORT /OUT_A /OUT_B shortctl 0 SWSHORT
.tran 20n 8m uic
.options method=gear
.ic v(/vref_raw)=2.5 v(/vref)=2.5 v(/inac)=2.5 v(/inv)=2.5 v(/tri)=2.5 v(/e_a)=2.5 v(/e_b)=2.5 v(/ecmp_a)=2.5 v(/ecmp_b)=2.5 v(/out_a)=12 v(/out_b)=12 v(/sw_a)=12 v(/sw_b)=12 v(/vb_a)=23.4 v(/vb_b)=23.4 v(/fault)=0
C37 /OUT_B GND 220n
C23 +5V GND 100n
C24 +5V GND 100n
R40 +5V /VTH 100k
C39 Net-_U16-+_ GND 470p
R42 /SENSE_A Net-_U16-+_ 10k
R43 /FAULT Net-_U16-+_ 100k
R41 /VTH GND 5.1k
D8 Net-_D8-A_ /FAULT D1N4148W
XU16 Net-_U16-+_ /VTH +5V GND Net-_D8-A_ COMP_RR
C40 +5V GND 100n
R46 /FAULT GND 100k
XQ5 /HIN_A /FAULT GND NMOS_2N7002
XQ6 /LIN_A /FAULT GND NMOS_2N7002
XQ7 /HIN_B /FAULT GND NMOS_2N7002
XQ8 /LIN_B /FAULT GND NMOS_2N7002
C41 Net-_U17-+_ GND 470p
R45 /FAULT Net-_U17-+_ 100k
XU17 Net-_U17-+_ /VTH +5V GND Net-_D9-A_ COMP_RR
D9 Net-_D9-A_ /FAULT D1N4148W
C42 +5V GND 100n
R44 /SENSE_B Net-_U17-+_ 10k
R2 Net-_U1--_ Net-_C1-Pad1_ 15k
C1 Net-_C1-Pad1_ GND 470p
R4 Net-_C1-Pad1_ GND 10k
R1 /INV Net-_U1--_ 10k
R3 /SW_A Net-_C1-Pad1_ 38.3k
C8 GND +12V 100n
C6 /HIN_A GND 120p
XU4 +12V /HIN_A /LIN_A GND Net-_U4-LO_ /SW_A Net-_U4-HO_ /VB_A HBRIDGE_DRV
D3 +12V Net-_D3-K_ D1N4148W
C7 /LIN_A GND 120p
XU1 /VREF Net-_U1--_ +5V GND /E_A OPAMP_RR
C3 +5V GND 100n
R22 /ECMP_A /VREF 82k
R21 /E_A /ECMP_A 220k
C2 Net-_U1--_ /E_A 68p
C4 +5V GND 100n
R6 Net-_D2-K_ /LIN_A 2.2k
D2 /LIN_A Net-_D2-K_ D1N4148W
R5 Net-_D1-K_ /HIN_A 2.2k
D1 /HIN_A Net-_D1-K_ D1N4148W
XU2 /ECMP_A /TRI +5V GND Net-_D1-K_ COMP_RR
XU3 /TRI /ECMP_A +5V GND Net-_D2-K_ COMP_RR
C5 +5V GND 100n
C18 +5V GND 10u
R16 +5V /VREF_RAW 10k
C16 +12V GND 10u
XU5 +24V +12V GND LDO_12V
C15 +24V GND 100n
C17 +12V GND 100n
C14 +24V GND 470u
XU6 +12V +5V GND LDO_5V
C36 +5V GND 100n
XU12 /TRI /ECMP_B +5V GND Net-_D6-K_ COMP_RR
XU11 /ECMP_B /TRI +5V GND Net-_D7-K_ COMP_RR
C29 +5V GND 100n
R30 Net-_U13-HO_ Net-_Q3-G_ 4.7
R33 Net-_Q3-G_ /SW_B 10k
XU13 +12V /HIN_B /LIN_B GND Net-_U13-LO_ /SW_B Net-_U13-HO_ /VB_B HBRIDGE_DRV
XQ4 /SW_B Net-_Q4-G_ /SENSE_B NMOS_60V
R27 Net-_Q4-G_ /SENSE_B 10k
R39 /SENSE_B GND 25m
R28 Net-_U13-LO_ Net-_Q4-G_ 4.7
XQ3 +24V Net-_Q3-G_ /SW_B NMOS_60V
D6 /LIN_B Net-_D6-K_ D1N4148W
R26 Net-_D6-K_ /LIN_B 2.2k
C30 GND +12V 100n
C28 /LIN_B GND 120p
R24 Net-_D7-K_ /HIN_B 2.2k
D7 /HIN_B Net-_D7-K_ D1N4148W
C27 /HIN_B GND 120p
D5 +12V Net-_D5-K_ D1N4148W
C35 /VB_B /SW_B 1u
C31 +24V GND 4.7u
C34 +24V GND 100n
L3 /SW_B /OUT_B 15u
R29 Net-_D5-K_ /VB_B 10
C21 /VREF_RAW GND 10u
R17 /VREF_RAW GND 10k
V2 /AUDIO_IN GND DC 0 SIN( 0 0.3 1k 0 0 0 ) AC 1
V1 +24V GND DC 24
C26 +5V GND 100n
XU14 /VREF Net-_U14--_ +5V GND /E_B OPAMP_RR
R35 /E_B /ECMP_B 220k
R36 /ECMP_B /VREF 82k
C33 Net-_U14--_ /E_B 68p
R25 Net-_U14--_ Net-_C32-Pad1_ 15k
R32 /INAC Net-_U14--_ 10k
R31 /SW_B Net-_C32-Pad1_ 38.3k
R34 Net-_C32-Pad1_ GND 10k
C32 Net-_C32-Pad1_ GND 470p
R9 Net-_U4-LO_ Net-_Q2-G_ 4.7
XQ2 /SW_A Net-_Q2-G_ /SENSE_A NMOS_60V
R10 Net-_Q2-G_ /SENSE_A 10k
R7 Net-_U4-HO_ Net-_Q1-G_ 4.7
R8 Net-_Q1-G_ /SW_A 10k
R38 /SENSE_A GND 25m
XQ1 +24V Net-_Q1-G_ /SW_A NMOS_60V
XU8 Net-_U8-+_ /VREF +5V GND Net-_R19-Pad2_ COMP_RR
R19 Net-_U8-+_ Net-_R19-Pad2_ 24.9k
R20 Net-_R19-Pad2_ Net-_U9--_ 10k
C22 Net-_U9--_ /TRI 250p
XU9 /VREF Net-_U9--_ +5V GND /TRI OPAMP_RR
C11 /VB_A /SW_A 1u
R11 Net-_D3-K_ /VB_A 10
L1 /SW_A /OUT_A 15u
C12 /OUT_A GND 220n
C10 +24V GND 100n
C9 +24V GND 4.7u
R37 /OUT_A /OUT_B 4
R47 /OUT_A Net-_C43-Pad1_ 6.8
XU15 /OUT_A /OUT_B /OUT_DIFF DIFFPROBE
C44 Net-_C44-Pad1_ GND 470n
R48 /OUT_B Net-_C44-Pad1_ 6.8
C43 Net-_C43-Pad1_ GND 470n
C38 /OUT_A /OUT_B 680n
R15 Net-_U7--_ /INV 10k
XU7 /VREF Net-_U7--_ +5V GND /INV OPAMP_RR
C20 +5V GND 100n
R14 /INAC Net-_U7--_ 10k
R18 /TRI Net-_U8-+_ 10k
XU10 /VREF_RAW /VREF +5V GND /VREF OPAMP_RR
C19 /AUDIO_IN /INAC 1u
R13 /VREF /INAC 47k
.end
