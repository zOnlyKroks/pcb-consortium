* NixiClockV1 HV boost (power.kicad_sch): LM3478 -> 185 V, 9 V in
* Refs/values match the schematic. Q101, D103, D105, D104, L101 DCR and C106 ESR are generic models (no vendor SPICE).
.include LM3478_TRANS.lib

* 9 V from J102 through D105 (SS34)
Vsrc nin 0 PWL(0 0 100u 9)
D105 nin VIN SS34
C101 VIN 0 10u
C102 VIN 0 10u
C105 VIN 0 10u

* controller supply filter
R117 VIN VCC 10
C111 VCC 0 100n

XU102 0 COMP DR FASD FB SRC 0 VCC LM3478_TRANS PARAMS: SS=0

* gate drive and MOSFET
R103 DR G 10
R106 G SRC 10k
M101 SW G SRC SRC HSU5N25
Cgs G SRC 300p
Cgd G SW 15p
R101 SRC 0 0.1

* power stage
L101 VIN LX 100u
RL101 LX SW 0.2
D103 SW HV ES1J
C106 HV HVc 2.2u
RC106 HVc 0 0.5
C107 HV 0 1n

* feedback / compensation / frequency
R107 HV FBm 1MEG
R108 FBm FB 1MEG
R109 FB 0 13.7k
R111 COMP CC 10k
C112 CC 0 100n
R105 FASD 0 200k
D104 0 FASD D1N4148

* tube load: ~4 mA, step to ~8 mA between 8 ms and 10 ms
Rload HV 0 46k
Rstep HV STP 46k
S1 STP 0 CTL 0 SWL
Vctl CTL 0 PULSE(0 1 8m 10u 10u 2m 1)

.model SWL SW(Vt=0.5 Ron=1 Roff=1G)
.model HSU5N25 NMOS(LEVEL=1 VTO=3 KP=1.2 RD=0.4 RS=0.05 CBD=40p IS=1e-12)
.model ES1J D(IS=1e-12 N=2 RS=0.3 CJO=10p TT=35n BV=600)
.model SS34 D(IS=2.8e-8 N=1 RS=0.03 CJO=200p BV=40)
.model D1N4148 D(IS=2.52n RS=0.568 N=1.752 CJO=4p TT=20n BV=100)

.options reltol=1e-3 abstol=1e-9 vntol=1e-5 method=gear
.tran 20n 12m 0 20n
.end
