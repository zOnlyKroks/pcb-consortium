.title KiCad schematic
.include "C:/Users/finnr/Desktop/pcb-consortium/Misc/BTBox-ADAU1701/sim/models/DIP4_GAIN.lib"
.include "C:/Users/finnr/Desktop/pcb-consortium/Misc/BTBox-ADAU1701/sim/models/J_ADAU_STUB.lib"
.include "C:/Users/finnr/Desktop/pcb-consortium/Misc/BTBox-ADAU1701/sim/models/TPA3116D2_BTBOX.lib"
.model __D3 D
+           is=10u
+           rs=0.015
+           n=1.1
+           bv=40
.tran 2u 10m
RJ10 Net-_J10-Pin_1_ /Amp/SPK_RN 4
XJ11 GND +3V3 /Amp/AUDIO0 /Amp/AUDIO1 /Amp/AMP_SD /Amp/AMP_FAULT /Amp/AMP_MUTE /Amp/AGND_SENSE J_ADAU_STUB amp=0.35 f=1k
R31 Net-_J12-Pin_1_ Net-_C61-Pad1_ 3.3
C60 Net-_J12-Pin_1_ GND 10n
C59 Net-_J12-Pin_1_ GND 1u
C50 /Amp/SPK_LN GND 10n
R28 /Amp/SPK_LN Net-_C52-Pad1_ 3.3
C48 /Amp/SPK_LN GND 1u
C52 Net-_C52-Pad1_ GND 1n
C56 /Amp/SPK_RN GND 1u
C47 Net-_J10-Pin_1_ GND 1u
C51 Net-_C51-Pad1_ GND 1n
C49 Net-_J10-Pin_1_ GND 10n
R27 Net-_J10-Pin_1_ Net-_C51-Pad1_ 3.3
R30 /Amp/SPK_RN Net-_C58-Pad1_ 3.3
C57 /Amp/SPK_RN GND 10n
C58 Net-_C58-Pad1_ GND 1n
L3 Net-_U7-OUTNL_ /Amp/SPK_LN 10u
L4 /Amp/OUTNR /Amp/SPK_RN 10u
C44 Net-_U7-AVCC_ GND 100n
R26 Net-_U7-AVCC_ +24V 10
C43 +24V GND 1n
C46 +24V GND 220u
C45 +24V GND 100n
L2 Net-_U7-OUTPR_ Net-_J10-Pin_1_ 10u
R37 /Amp/GAIN_36 GND 47k
R36 /Amp/GVDD /Amp/GAIN_36 75k
RJ12 Net-_J12-Pin_1_ /Amp/SPK_LN 4
C61 Net-_C61-Pad1_ GND 1n
L5 /Amp/OUTPL Net-_J12-Pin_1_ 10u
XSW2 /Amp/GAIN_20 /Amp/GAIN_26 /Amp/GAIN_32 /Amp/GAIN_36 /Amp/AMP_GAIN /Amp/AMP_GAIN /Amp/AMP_GAIN /Amp/AMP_GAIN DIP4_GAIN sel=2
R35 /Amp/GAIN_32 GND 39k
R34 /Amp/GVDD /Amp/GAIN_32 100k
R33 /Amp/GAIN_20 GND 5.6k
XU7 GND /Amp/AMP_SDZ /Amp/AMP_FAULT Net-_U7-RINP_ Net-_U7-RINN_ /Amp/GVDD /Amp/GVDD /Amp/AMP_GAIN GND /Amp/AMP_INLP /Amp/AMP_INLN /Amp/AMP_MUTE GND GND GND unconnected-_U7-SYNC-Pad16_ Net-_U7-AVCC_ +24V +24V Net-_U7-BSNL_ Net-_U7-OUTNL_ GND /Amp/OUTPL Net-_U7-BSPL_ GND Net-_U7-BSNR_ /Amp/OUTNR GND Net-_U7-OUTPR_ Net-_U7-BSPR_ +24V +24V GND TPA3116D2_BTBOX
L1 Net-_U6-SW_ +3V3 4.7u
C32 +24V GND 100n
C31 Net-_U6-BST_ Net-_U6-SW_ 100n
C30 +24V GND 220u
D3 Net-_D3-A_ +24V __D3
R24 /Amp/GAIN_26 /Amp/GVDD 100k
R21 /Amp/AMP_SD +3V3 100k
C54 /Amp/AUDIO1 /Amp/AMP_INLP 2.2u
R20 /Amp/AMP_FAULT +3V3 10k
R22 /Amp/AMP_SDZ +24V 100k
R25 /Amp/GAIN_26 GND 20k
C37 /Amp/GVDD GND 1u
C55 /Amp/AMP_INLN /Amp/AGND_SENSE 2.2u
C34 +3V3 GND 22u
C35 Net-_U7-RINN_ /Amp/AGND_SENSE 2.2u
C36 /Amp/AUDIO0 Net-_U7-RINP_ 2.2u
R23 /Amp/AMP_MUTE +3V3 100k
C33 +3V3 GND 22u
C40 /Amp/OUTNR Net-_U7-BSNR_ 220n
C39 Net-_U7-BSPR_ Net-_U7-OUTPR_ 220n
C42 Net-_U7-OUTNL_ Net-_U7-BSNL_ 220n
C41 Net-_U7-BSPL_ /Amp/OUTPL 220n
C38 Net-_U7-AVCC_ GND 1u
C29 +24V GND 10u
R19 +24V Net-_U6-EN_ 100k
C28 +24V GND 10u
VJ9 Net-_F1-Pad1_ GND DC 24
RF1 Net-_F1-Pad1_ Net-_D3-A_ 0.05
.end
